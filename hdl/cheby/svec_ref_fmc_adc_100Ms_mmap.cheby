# SPDX-FileCopyrightText: 2020 CERN (home.cern)
#
# SPDX-License-Identifier: CC-BY-SA-4.0 OR CERN-OHL-W-2.0+ OR GPL-2.0-or-later

memory-map:
  name: svec_ref_fmc_adc_100m_mmap
  bus: wb-32-be
  description: SVEC FMC-ADC-100M memory map
  size: 0x10000
  x-hdl:
    busgroup: True
    pipeline: wr,rd
  children:
    - submap:
        name: metadata
        address: 0x4000
        size: 0x40
        interface: wb-32-be
        x-hdl:
          busgroup: True
        description: a ROM containing the application metadata
    - submap:
        name: fmc1_adc_mezzanine
        address: 0x6000
        description: FMC ADC Mezzanine slot 1
        filename: fmc_adc_mezzanine_mmap.cheby
    - submap:
        name: fmc2_adc_mezzanine
        address: 0x8000
        description: FMC ADC Mezzanine slot 2
        filename: fmc_adc_mezzanine_mmap.cheby
