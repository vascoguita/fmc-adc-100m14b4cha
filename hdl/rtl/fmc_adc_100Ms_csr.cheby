memory-map:
  bus: wb-32-be
  name: fmc_adc_100ms_csr
  description: FMC ADC 100MS/s core registers
  comment: |
    Wishbone slave for FMC ADC 100MS/s core
  x-hdl:
    busgroup: True
    iogroup: fmc_adc_100ms_csr
  children:
  - reg:
      name: ctl
      address: 0x00000000
      width: 32
      access: rw
      description: Control register
      x-hdl:
        write-strobe: True
      children:
      - field:
          name: fsm_cmd
          range: 1-0
          description: State machine commands (ignore on read)
          comment: |
            1: ACQ_START (start acquisition, only when FSM is idle)
            2: ACQ_STOP (stop acquisition, anytime)
          x-hdl:
            type: wire
      - field:
          name: fmc_clk_oe
          range: 2
          description: FMC Si750 output enable
      - field:
          name: offset_dac_clr_n
          range: 3
          description: Offset DACs clear (active low)
      - field:
          name: man_bitslip
          range: 4
          description: Manual serdes bitslip (ignore on read)
          x-hdl:
            type: wire
      - field:
          name: test_data_en
          range: 5
          description: Enable test data
          comment: |
            Write the DDR RAM address counter value instead of ADC data to DDR.
            Note that no timetags are appended at the end of test data.
      - field:
          name: trig_led
          range: 6
          description: Manual TRIG LED
          comment: |
            Manual control of the front panel TRIG LED
      - field:
          name: acq_led
          range: 7
          description: Manual ACQ LED
          comment: |
            Manual control of the front panel ACQ LED
      - field:
          name: clear_trig_stat
          range: 8
          description: Clear trigger status
          comment: |
            Write 1 to clear the last trigger status register. Auto-resets to zero.
          x-hdl:
            type: wire
  - reg:
      name: sta
      address: 0x00000004
      width: 32
      access: ro
      description: Status register
      children:
      - field:
          name: fsm
          range: 2-0
          description: State machine status
          comment: |
            States:
            0: illegal
            1: IDLE
            2: PRE_TRIG
            3: WAIT_TRIG
            4: POST_TRIG
            5: TRIG_TAG
            6: DECR_SHOT
            7: illegal
      - field:
          name: serdes_pll
          range: 3
          description: SerDes PLL status
          comment: |
            Sampling clock recovery PLL.
            0: not locked
            1: locked
      - field:
          name: serdes_synced
          range: 4
          description: SerDes synchronization status
          comment: |
            0: bitslip in progress
            1: serdes synchronized
      - field:
          name: acq_cfg
          range: 5
          description: Acquisition configuration status
          comment: |
            0: Unauthorised acquisition configuration (will prevent acquisition to start)
            1: Valid acquisition configuration
            - Shot number > 0
            - Post-trigger sample > 0
  - reg:
      name: trig_stat
      address: 0x00000008
      width: 32
      access: ro
      description: Trigger status
      comment: |
        Shows the source(s) of the last received trigger.
      children:
      - field:
          name: ext
          range: 0
          description: External trigger input
          comment: |
            0: not triggered
            1: triggered
      - field:
          name: sw
          range: 1
          description: Software trigger
          comment: |
            0: not triggered
            1: triggered
      - field:
          name: time
          range: 4
          description: Timetag trigger
          comment: |
            0: not triggered
            1: triggered
      - field:
          name: ch1
          range: 8
          description: Channel 1 internal threshold trigger
          comment: |
            0: not triggered
            1: triggered
      - field:
          name: ch2
          range: 9
          description: Channel 2 internal threshold trigger
          comment: |
            0: not triggered
            1: triggered
      - field:
          name: ch3
          range: 10
          description: Channel 3 internal threshold trigger
          comment: |
            0: not triggered
            1: triggered
      - field:
          name: ch4
          range: 11
          description: Channel 4 internal threshold trigger
          comment: |
            0: not triggered
            1: triggered
  - reg:
      name: trig_en
      address: 0x0000000c
      width: 32
      access: rw
      description: Trigger enable
      children:
      - field:
          name: ext
          range: 0
          description: External trigger input
          comment: |
            0: disable
            1: enable
      - field:
          name: sw
          range: 1
          description: Software trigger
          comment: |
            Always enabled
          x-hdl:
            type: wire
      - field:
          name: time
          range: 4
          description: Timetag trigger
          comment: |
            0: disable
            1: enable
      - field:
          name: aux_time
          range: 5
          description: Auxiliary timetag trigger
          comment: |
            Always enabled
          x-hdl:
            type: wire
      - field:
          name: ch1
          range: 8
          description: Channel 1 internal threshold trigger
          comment: |
            0: disable
            1: enable
      - field:
          name: ch2
          range: 9
          description: Channel 2 internal threshold trigger
          comment: |
            0: disable
            1: enable
      - field:
          name: ch3
          range: 10
          description: Channel 3 internal threshold trigger
          comment: |
            0: disable
            1: enable
      - field:
          name: ch4
          range: 11
          description: Channel 4 internal threshold trigger
          comment: |
            0: disable
            1: enable
  - reg:
      name: trig_pol
      address: 0x00000010
      width: 32
      access: rw
      description: Trigger polarity
      children:
      - field:
          name: ext
          range: 0
          description: External trigger input
          comment: |
            0: positive edge/slope
            1: negative edge/slope
      - field:
          name: ch1
          range: 8
          description: Channel 1 internal threshold trigger
          comment: |
            0: positive edge/slope
            1: negative edge/slope
      - field:
          name: ch2
          range: 9
          description: Channel 2 internal threshold trigger
          comment: |
            0: positive edge/slope
            1: negative edge/slope
      - field:
          name: ch3
          range: 10
          description: Channel 3 internal threshold trigger
          comment: |
            0: positive edge/slope
            1: negative edge/slope
      - field:
          name: ch4
          range: 11
          description: Channel 4 internal threshold trigger
          comment: |
            0: positive edge/slope
            1: negative edge/slope
  - reg:
      name: ext_trig_dly
      address: 0x00000014
      width: 32
      access: rw
      description: External trigger delay
      comment: |
        Delay to apply on the trigger in sampling clock period.
        The default clock frequency is 100MHz (period = 10ns).
  - reg:
      name: sw_trig
      address: 0x00000018
      width: 32
      access: wo
      description: Software trigger
      comment: |
        Writing (anything) to this register generates a software trigger.
      x-hdl:
        type: wire
        write-strobe: True
  - reg:
      name: shots
      address: 0x0000001c
      width: 32
      access: rw
      description: Number of shots
      children:
      - field:
          name: nbr
          range: 15-0
          description: Number of shots
          comment: |
            Number of shots required in multi-shot mode, set to one for single-shot mode.
      - field:
          name: remain
          range: 31-16
          description: Remaining shots counter
          comment: |
            Counts the number of remaining shots to acquire.
          x-hdl:
            type: wire
  - reg:
      name: multi_depth
      address: 0x00000020
      width: 32
      access: ro
      description: Multi-shot sample depth register
      comment: |
        Maximum sample depth allowed in multi-shot acquisition mode, excluding two samples already reserved for time tag
  - reg:
      name: trig_pos
      address: 0x00000024
      width: 32
      access: ro
      description: Trigger address register
      comment: |
        Trigger address in DDR memory.
        Only used in single-shot mode.
  - reg:
      name: fs_freq
      address: 0x00000028
      width: 32
      access: ro
      description: Sampling clock frequency
      comment: |
        ADC sampling clock frequency in Hz
  - reg:
      name: downsample
      address: 0x0000002c
      width: 32
      access: rw
      description: Downsampling ratio
      comment: |
        Downsampling ratio. Takes one sample every N samples and discards the others (N = downsampling ratio)
  - reg:          
      name: pre_samples
      address: 0x00000030
      width: 32
      access: rw
      description: Pre-trigger samples
      comment: |
        Number of requested pre-trigger samples (>1).
  - reg:
      name: post_samples
      address: 0x00000034
      width: 32
      access: rw
      description: Post-trigger samples
      comment: |
        Number of requested post-trigger samples (>1).
  - reg:
      name: samples_cnt
      address: 0x00000038
      width: 32
      access: ro
      description: Samples counter
      comment: |
        Counts the number of samples.
        It is reset on START and then counts the number of pre-trigger + post-trigger samples
  - reg:
      name: ch1_ctl
      address: 0x00000080
      width: 32
      access: rw
      description: Channel 1 control register
      children:
      - field:
          name: ssr
          range: 6-0
          description: Solid state relays control for channel 1
          comment: |
            Controls input voltage range, termination and DC offset error calibration
            0x23: 100mV range
            0x11: 1V range
            0x45: 10V range
            0x00: Open input
            0x42: 100mV range calibration
            0x40: 1V range calibration
            0x44: 10V range calibration
            Bit3 is indepandant of the others and enables the 50ohms termination.
  - reg:
      name: ch1_sta
      address: 0x00000084
      width: 32
      access: ro
      description: Channel 1 status register
      children:
      - field:
          name: val
          range: 15-0
          description: Channel 1 current ADC value
          comment: |
            Current ADC raw value. The format depends on ADC configuration; Upon reset, the ADC is
            configured for "offset binary". The FMC-ADC driver when loaded, will change this to
            binary two\'s complement.
  - reg:
      name: ch1_calib
      address: 0x00000088
      width: 32
      access: rw
      description: Channel 1 calibration register
      children:
      - field:
          name: gain
          range: 15-0
          description: Gain calibration for channel 1
          comment: |
            Gain applied to all data coming from the ADC.
            Fixed point format:
            Bit 15 = 2^0, bit 14 = 2^(-1), bit 13 = 2^(-2), ... , bit 1 = 2^(-14), bit 0 = 2^(-15)
      - field:
          name: offset
          range: 31-16
          description: Offset calibration for channel 1
          comment: |
            Offset applied to all data coming from the ADC. The format is binary two\'s complement.
  - reg:
      name: ch1_sat
      address: 0x0000008c
      width: 32
      access: rw
      description: Channel 1 saturation register
      children:
      - field:
          name: val
          range: 14-0
          description: Saturation value for channel 1
          comment: |
            Saturation applied to all data coming from the offset/gain correction block. The format is 15-bit unsigned.
  - reg:
      name: ch1_trig_thres
      address: 0x00000090
      width: 32
      access: rw
      description: Channel 1 trigger threshold configuration register
      children:
      - field:
          name: val
          range: 15-0
          description: Threshold for internal trigger
          comment: |
            Treated as binary two\'s complement and compared to raw ADC data.
      - field:
          name: hyst
          range: 31-16
          description: Internal trigger threshold hysteresis
          comment: |
            Configures the internal trigger threshold hysteresis.
            The value is always unsigned, and the gateware will subtract/add it based on the configured trigger polarity.
  - reg:
      name: ch1_trig_dly
      address: 0x00000094
      width: 32
      access: rw
      description: Channel 1 trigger delay
      comment: |
        Delay to apply on the trigger in sampling clock period.
        The default clock frequency is 100MHz (period = 10ns).
  - reg:
      name: ch2_ctl
      address: 0x000000c0
      width: 32
      access: rw
      description: Channel 2 control register
      children:
      - field:
          name: ssr
          range: 6-0
          description: Solid state relays control for channel 2
          comment: |
            Controls input voltage range, termination and DC offset error calibration
            0x23: 100mV range
            0x11: 1V range
            0x45: 10V range
            0x00: Open input
            0x42: 100mV range calibration
            0x40: 1V range calibration
            0x44: 10V range calibration
            Bit3 is indepandant of the others and enables the 50ohms termination.
  - reg:
      name: ch2_sta
      address: 0x000000c4
      width: 32
      access: ro
      description: Channel 2 status register
      children:
      - field:
          name: val
          range: 15-0
          description: Channel 2 current ACD value
          comment: |
            Current ADC raw value. The format depends on ADC configuration; Upon reset, the ADC is
            configured for "offset binary". The FMC-ADC driver when loaded, will change this to
            binary two\'s complement.
  - reg:
      name: ch2_calib
      address: 0x000000c8
      width: 32
      access: rw
      description: Channel 2 calibration register
      children:
      - field:
          name: gain
          range: 15-0
          description: Gain calibration for channel 2
          comment: |
            Gain applied to all data coming from the ADC.
            Fixed point format:
            Bit 15 = 2^0, bit 14 = 2^(-1), bit 13 = 2^(-2), ... , bit 1 = 2^(-14), bit 0 = 2^(-15)
      - field:
          name: offset
          range: 31-16
          description: Offset calibration for channel 2
          comment: |
            Offset applied to all data coming from the ADC. The format is binary two\'s complement.
  - reg:
      name: ch2_sat
      address: 0x000000cc
      width: 32
      access: rw
      description: Channel 2 saturation register
      children:
      - field:
          name: val
          range: 14-0
          description: Saturation value for channel 2
          comment: |
            Saturation applied to all data coming from the offset/gain correction block. The format is 15-bit unsigned.
  - reg:
      name: ch2_trig_thres
      address: 0x000000d0
      width: 32
      access: rw
      description: Channel 2 trigger threshold configuration register
      children:
      - field:
          name: val
          range: 15-0
          description: Threshold for internal trigger
          comment: |
            Treated as binary two\'s complement and compared to raw ADC data.
      - field:
          name: hyst
          range: 31-16
          description: Internal trigger threshold hysteresis
          comment: |
            Configures the internal trigger threshold hysteresis.
            The value is always unsigned, and the gateware will subtract/add it based on the configured trigger polarity.
  - reg:
      name: ch2_trig_dly
      address: 0x000000d4
      width: 32
      access: rw
      description: Channel 2 trigger delay
      comment: |
        Delay to apply on the trigger in sampling clock period.
        The default clock frequency is 100MHz (period = 10ns).
  - reg:
      name: ch3_ctl
      address: 0x00000100
      width: 32
      access: rw
      description: Channel 3 control register
      children:
      - field:
          name: ssr
          range: 6-0
          description: Solid state relays control for channel 3
          comment: |
            Controls input voltage range, termination and DC offset error calibration
            0x23: 100mV range
            0x11: 1V range
            0x45: 10V range
            0x00: Open input
            0x42: 100mV range calibration
            0x40: 1V range calibration
            0x44: 10V range calibration
            Bit3 is indepandant of the others and enables the 50ohms termination.
  - reg:
      name: ch3_sta
      address: 0x00000104
      width: 32
      access: ro
      description: Channel 3 status register
      children:
      - field:
          name: val
          range: 15-0
          description: Channel 3 current ADC value
          comment: |
            Current ADC raw value. The format depends on ADC configuration; Upon reset, the ADC is
            configured for "offset binary". The FMC-ADC driver when loaded, will change this to
            binary two\'s complement.
  - reg:
      name: ch3_calib
      address: 0x00000108
      width: 32
      access: rw
      description: Channel 3 calibration register
      children:
      - field:
          name: gain
          range: 15-0
          description: Gain calibration for channel 3
          comment: |
            Gain applied to all data coming from the ADC.
            Fixed point format:
            Bit 15 = 2^0, bit 14 = 2^(-1), bit 13 = 2^(-2), ... , bit 1 = 2^(-14), bit 0 = 2^(-15)
      - field:
          name: offset
          range: 31-16
          description: Offset calibration for channel 3
          comment: |
            Offset applied to all data coming from the ADC. The format is binary two\'s complement.
  - reg:
      name: ch3_sat
      address: 0x0000010c
      width: 32
      access: rw
      description: Channel 3 saturation register
      children:
      - field:
          name: val
          range: 14-0
          description: Saturation value for channel 3
          comment: |
            Saturation applied to all data coming from the offset/gain correction block. The format is 15-bit unsigned.
  - reg:
      name: ch3_trig_thres
      address: 0x00000110
      width: 32
      access: rw
      description: Channel 3 trigger threshold configuration register
      children:
      - field:
          name: val
          range: 15-0
          description: Threshold for internal trigger
          comment: |
            Treated as binary two\'s complement and compared to raw ADC data.
      - field:
          name: hyst
          range: 31-16
          description: Internal trigger threshold hysteresis
          comment: |
            Configures the internal trigger threshold hysteresis.
            The value is always unsigned, and the gateware will subtract/add it based on the configured trigger polarity.
  - reg:
      name: ch3_trig_dly
      address: 0x00000114
      width: 32
      access: rw
      description: Channel 3 trigger delay
      comment: |
        Delay to apply on the trigger in sampling clock period.
        The default clock frequency is 100MHz (period = 10ns).
  - reg:
      name: ch4_ctl
      address: 0x00000140
      width: 32
      access: rw
      description: Channel 4 control register
      children:
      - field:
          name: ssr
          range: 6-0
          description: Solid state relays control for channel 4
          comment: |
            Controls input voltage range, termination and DC offset error calibration
            0x23: 100mV range
            0x11: 1V range
            0x45: 10V range
            0x00: Open input
            0x42: 100mV range calibration
            0x40: 1V range calibration
            0x44: 10V range calibration
            Bit3 is indepandant of the others and enables the 50ohms termination.
  - reg:
      name: ch4_sta
      address: 0x00000144
      width: 32
      access: ro
      description: Channel 4 status register
      children:
      - field:
          name: val
          range: 15-0
          description: Channel 4 current ADC value
          comment: |
            Current ADC raw value. The format depends on ADC configuration; Upon reset, the ADC is
            configured for "offset binary". The FMC-ADC driver when loaded, will change this to
            binary two\'s complement.
  - reg:
      name: ch4_calib
      address: 0x00000148
      width: 32
      access: rw
      description: Channel 4 gain calibration register
      children:
      - field:
          name: gain
          range: 15-0
          description: Gain calibration for channel 4
          comment: |
            Gain applied to all data coming from the ADC.
            Fixed point format:
            Bit 15 = 2^0, bit 14 = 2^(-1), bit 13 = 2^(-2), ... , bit 1 = 2^(-14), bit 0 = 2^(-15)
      - field:
          name: offset
          range: 31-16
          description: Offset calibration for channel 4
          comment: |
            Offset applied to all data coming from the ADC. The format is binary two\'s complement.
  - reg:
      name: ch4_sat
      address: 0x0000014c
      width: 32
      access: rw
      description: Channel 4 saturation register
      children:
      - field:
          name: val
          range: 14-0
          description: Saturation value for channel 4
          comment: |
            Saturation applied to all data coming from the offset/gain correction block. The format is 15-bit unsigned.
  - reg:
      name: ch4_trig_thres
      address: 0x00000150
      width: 32
      access: rw
      description: Channel 4 trigger threshold configuration register
      children:
      - field:
          name: val
          range: 15-0
          description: Threshold for internal trigger
          comment: |
            Treated as binary two\'s complement and compared to raw ADC data.
      - field:
          name: hyst
          range: 31-16
          description: Internal trigger threshold hysteresis
          comment: |
            Configures the internal trigger threshold hysteresis.
            The value is always unsigned, and the gateware will subtract/add it based on the configured trigger polarity.
  - reg:
      name: ch4_trig_dly
      address: 0x00000154
      width: 32
      access: rw
      description: Channel 4 trigger delay
      comment: |
        Delay to apply on the trigger in sampling clock period.
        The default clock frequency is 100MHz (period = 10ns).
